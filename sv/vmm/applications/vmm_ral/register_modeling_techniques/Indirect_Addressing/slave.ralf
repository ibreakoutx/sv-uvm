block slave {
   bytes 4;
   register CHIP_ID (CHIP_ID) @'h0000 {
      field REVISION_ID {
         bits 8;
         access ro;
         reset 'h03;
      }
      field CHIP_ID {
         bits 8;
         access ro;
         reset 'h5A;
      }
      field PRODUCT_ID {
         bits 10;
         access ro;
         reset 'h176;
      }
   }
   register STATUS @'h0004 {
      field BUSY (BUSY) {
         bits 1;
         access ro;
         reset 'h0;
      }
      field TXEN (TXEN) {
         bits 1;
         access rw;
         reset 'h0;
         constraint valid {}
      }
      field MODE (MODE) {
         bits 3;
         access rw;
         reset 3'h0;
         constraint valid {
           value < 3'h6; 
         }
      }
      field READY (RDY) @16 {
         bits 1;
         access w1c;
         reset 'h0;
         constraint valid {}
      }
      constraint status_reg_valid {
        (MODE.value == 3'h5) -> TXEN.value != 1'b1;
      }
   }
   register MASK @'h0005 {
      field PROTECT (PROTECTED) {
         bits 1;
         access rw;
         reset 'h0;
      }
      field READY (RDY_MSK) @16 {
         bits 1;
         access rw;
         reset 'h0;
         constraint valid {}
      }
   }
   register CONFIG[3] (CONFIG%d) @'h0006 {
      field value {
         bits 32;
         access rw;
         reset 'hdeadbeef;
      }
   }
   # Introduce the index register
   register INDEX (COUNTER_INDEX) @'h0009 {
      field INDEX {
         bits 8;
         access rw;
      }
   }
   # Introduce the value register
   # user0 access  - stop default register tests.
   register RIdx (RIdx) @'h000a {
      field RIdx {
         bits 32;
         access user0;
      }
   }
   # COUNTERS address has become '@none'
   register COUNTERS[256] @none {
      field value {
         bits 32;
         access ru;
         reset 'hdead_dead;
      }
   }
   memory DMA_RAM (DMA) @'h0800 {
      size 1k;
      bits 32;
      access rw;
   }
}

