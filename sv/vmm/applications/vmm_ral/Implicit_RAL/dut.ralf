register CTRL_REG {
  bytes 1;
  field REG_VAL {
    bits  8;
    access rw;
    reset  1'b0;
  }
}

register DATA_REG {
  bytes 1;
  field REG_VAL {
    bits  8;
    access rw;
    reset  1'b0;
  }
}

register STATUS_REG {
  bytes 1;
  field WR_ERROR @0 {
    bits  1;
    access ro;
    reset  1'b0;
  }
  field RD_ERROR @4 {
    bits  1;
    access ro;
    reset  1'b0;
  }
}

block DUT_BLK {
  bytes 1;
  register STATUS_REG @8'h00;
  register CTRL_REG @8'h01;
  register DATA_REG @8'h02;
}

system DUT {
  bytes 1;
		block DUT_BLK;
}

